* task: 1  expect: netlist   (ideal VCVS instead of a transistor amplifier)
Vdd Vdd 0 5
Vin Vin 0 1.5
E1 Vout 0 Vin 0 -10
R1 Vout Vdd 1k
.end
