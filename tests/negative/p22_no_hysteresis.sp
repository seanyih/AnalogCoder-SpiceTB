* task: 22  expect: function   (plain comparator, no positive feedback -> no hysteresis)
.include opamp.lib
Xop Vin ref Vout SingleStageOpamp
Vref ref 0 2.5
Vin Vin 0 1.0
.end
