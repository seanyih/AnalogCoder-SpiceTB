* task: 1  expect: netlist   (only the problem's own library files may be included)
.include /home/user/AnalogCoder-SpiceTB/reference/p01.sp
.end
