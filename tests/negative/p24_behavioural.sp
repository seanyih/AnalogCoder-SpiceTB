* task: 24  expect: netlist   (behavioural sources are not allowed)
VDD vdd 0 1
B1 clk_p 0 V = v(clk_ref)
R1 clk_p 0 1k
.end
